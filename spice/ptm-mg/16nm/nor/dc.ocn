; nsc.ocn

; set correct license for checkout
envSetVal("license" "ADELicenseCheckoutOrder"  'string "GXL,L,XL")

; set up simulation environment
simulator('spectre)
; design("./design/netlist")
design("./16nm/dc/netlist")
resultsDir(".")
desVar( "tVDD" 0.85 )

; open output port for writing out results to a file
fp = outfile("./dc.txt" "w")

analysis('dc ?saveOppoint t ?oppoint "rawfile")
run

 ; Determine static noise margin using the minus one point strategy
selectResults('dc)
gvtc1 = deriv(v("outINV"))
gvtc2 = deriv(v("outNAND"))
gvtc3 = deriv(v("outNOR"))
gvtc4 = deriv(v("outBUF"))
gvtc5 = deriv(v("outXOR"))
gvtc6 = deriv(v("outTGXOR"))

;------------------------------------------------
; determine input/output margins for gate 1
;------------------------------------------------
; verifies both positive and negative gains
vil1 = cross(gvtc1 -1 1 'either)
vih1 = cross(gvtc1 -1 2 'either)
if( vil1 == nil (vil1 = cross(gvtc1 1 1 'either)))
if( vih1 == nil (vih1 = cross(gvtc1 1 2 'either)))

; considerating gate unateness, sometimes voh and vol must be swapped
voh1 = value(v("outINV") vil1)
vol1 = value(v("outINV") vih1)
if( voh1 < vol1 then
    aux = voh1
    voh1 = vol1
    vol1 = aux
)

;------------------------------------------------
; determine input/output margins for gate 2
;--------------'----------------------------------
; verifies both positive and negative gains
vil2 = cross(gvtc2 -1 1 'either)
vih2 = cross(gvtc2 -1 2 'either)
if( vil2 == nil (vil2 = cross(gvtc2 1 1 'either)))
if( vih2 == nil (vih2 = cross(gvtc2 1 2 'either)))

; considerating gate unateness, sometimes voh and vol must be swapped
voh2 = value(v("outNAND") vil2)
vol2 = value(v("outNAND") vih2)
if( voh2 < vol2 then
    aux = voh2
    voh2 = vol2
    vol2 = aux
)

;------------------------------------------------
; determine input/output margins for gate 3
;--------------'----------------------------------
; verifies both positive and negative gains
vil3 = cross(gvtc3 -1 1 'either)
vih3 = cross(gvtc3 -1 2 'either)
if( vil3 == nil (vil3 = cross(gvtc3 1 1 'either)))
if( vih3 == nil (vih3 = cross(gvtc3 1 2 'either)))

; considerating gate unateness, sometimes voh and vol must be swapped
voh3 = value(v("outNOR") vil3)
vol3 = value(v("outNOR") vih3)
if( voh3 < vol3 then
    aux = voh3
    voh3 = vol3
    vol3 = aux
)

;------------------------------------------------
; determine input/output margins for gate 4
;--------------'----------------------------------
; verifies both positive and negative gains
vil4 = cross(gvtc4 -1 1 'either)
vih4 = cross(gvtc4 -1 2 'either)
if( vil4 == nil (vil4 = cross(gvtc4 1 1 'either)))
if( vih4 == nil (vih4 = cross(gvtc4 1 2 'either)))

; considerating gate unateness, sometimes voh and vol must be swapped
voh4 = value(v("outBUF") vil4)
vol4 = value(v("outBUF") vih4)
if( voh4 < vol4 then
    aux = voh4
    voh4 = vol4
    vol4 = aux
)

;------------------------------------------------
; determine input/output margins for gate 5
;--------------'----------------------------------
; verifies both positive and negative gains
vil5 = cross(gvtc5 -1 1 'either)
vih5 = cross(gvtc5 -1 2 'either)
if( vil5 == nil (vil5 = cross(gvtc5 1 1 'either)))
if( vih5 == nil (vih5 = cross(gvtc5 1 2 'either)))

; considerating gate unateness, sometimes voh and vol must be swapped
voh5 = value(v("outXOR") vil5)
vol5 = value(v("outXOR") vih5)
if( voh5 < vol5 then
    aux = voh5
    voh5 = vol5
    vol5 = aux
)

;------------------------------------------------
; determine input/output margins for gate 6
;--------------'----------------------------------
; verifies both positive and negative gains
vil6 = cross(gvtc6 -1 1 'either)
vih6 = cross(gvtc6 -1 2 'either)
if( vil6 == nil (vil6 = cross(gvtc6 1 1 'either)))
if( vih6 == nil (vih6 = cross(gvtc6 1 2 'either)))

; considerating gate unateness, sometimes voh and vol must be swapped
voh6 = value(v("outTGXOR") vil6)
vol6 = value(v("outTGXOR") vih6)
if( voh6 < vol6 then
    aux = voh6
    voh6 = vol6
    vol6 = aux
)

;------------------------------------------------
; calculate noise margin
;------------------------------------------------

; gate 1
nmh_1 = voh1 - vih1
nml_1 = vil1 - vol1

; gate 2
nmh_2 = voh2 - vih2
nml_2 = vil2 - vol2

; gate 3
nmh_3 = voh3 - vih3
nml_3 = vil3 - vol3

; gate 4
nmh_4 = voh4 - vih4
nml_4 = vil4 - vol4

; gate 5
nmh_5 = voh5 - vih5
nml_5 = vil5 - vol5

; gate 6
nmh_6 = voh6 - vih6
nml_6 = vil6 - vol6

; gate 1 - gate 2
nmh_12 = voh1 - vih2
nml_12 = vil2 - vol1
if( nmh_12 < nml_12 snm_12=nmh_12 snm_12=nml_12 )

; gate 2 - gate 1
nmh_21 = voh2 - vih1
nml_21 = vil1 - vol2
if( nmh_21 < nml_21 snm_21=nmh_21 snm_21=nml_21 )

; gets the smallest from both
if( nmh_21 < nmh_12 nmh=nmh_21 nmh=nmh_12 )
if( nml_21 < nml_12 nml=nml_21 nml=nml_12 )
if( nmh < nml snm=nmh snm=nml )

;------------------------------------------------
; print results to the output file
;------------------------------------------------

fprintf(fp "#-------------------------------#\n")
fprintf(fp "#-           INVERTER          -#\n")
fprintf(fp "#-------------------------------#\n")
fprintf(fp "VIL = %10.6f\n" vil1)
fprintf(fp "VIH = %10.6f\n" vih1)
fprintf(fp "VOL = %10.6f\n" vol1)
fprintf(fp "VOH = %10.6f\n" voh1)
fprintf(fp "NMH = %10.6f\n" nmh_1)
fprintf(fp "NML = %10.6f\n\n" nml_1)

fprintf(fp "#-------------------------------#\n")
fprintf(fp "#-           NAND2             -#\n")
fprintf(fp "#-------------------------------#\n")
fprintf(fp "VIL = %10.6f\n" vil2)
fprintf(fp "VIH = %10.6f\n" vih2)
fprintf(fp "VOL = %10.6f\n" vol2)
fprintf(fp "VOH = %10.6f\n" voh2)
fprintf(fp "NMH = %10.6f\n" nmh_2)
fprintf(fp "NML = %10.6f\n\n" nml_2)

fprintf(fp "#-------------------------------#\n")
fprintf(fp "#-           NOR2              -#\n")
fprintf(fp "#-------------------------------#\n")
fprintf(fp "VIL = %10.6f\n" vil3)
fprintf(fp "VIH = %10.6f\n" vih3)
fprintf(fp "VOL = %10.6f\n" vol3)
fprintf(fp "VOH = %10.6f\n" voh3)
fprintf(fp "NMH = %10.6f\n" nmh_3)
fprintf(fp "NML = %10.6f\n\n" nml_3)

fprintf(fp "#-------------------------------#\n")
fprintf(fp "#-           BUFFER            -#\n")
fprintf(fp "#-------------------------------#\n")
fprintf(fp "VIL = %10.6f\n" vil4)
fprintf(fp "VIH = %10.6f\n" vih4)
fprintf(fp "VOL = %10.6f\n" vol4)
fprintf(fp "VOH = %10.6f\n" voh4)
fprintf(fp "NMH = %10.6f\n" nmh_4)
fprintf(fp "NML = %10.6f\n\n" nml_4)

fprintf(fp "#-------------------------------#\n")
fprintf(fp "#-           XOR2              -#\n")
fprintf(fp "#-------------------------------#\n")
fprintf(fp "VIL = %10.6f\n" vil5)
fprintf(fp "VIH = %10.6f\n" vih5)
fprintf(fp "VOL = %10.6f\n" vol5)
fprintf(fp "VOH = %10.6f\n" voh5)
fprintf(fp "NMH = %10.6f\n" nmh_5)
fprintf(fp "NML = %10.6f\n\n" nml_5)

fprintf(fp "#-------------------------------#\n")
fprintf(fp "#-           TG XOR2           -#\n")
fprintf(fp "#-------------------------------#\n")
fprintf(fp "VIL = %10.6f\n" vil6)
fprintf(fp "VIH = %10.6f\n" vih6)
fprintf(fp "VOL = %10.6f\n" vol6)
fprintf(fp "VOH = %10.6f\n" voh6)
fprintf(fp "NMH = %10.6f\n" nmh_6)
fprintf(fp "NML = %10.6f\n\n" nml_6)

; fprintf(fp "#-------------------------------#\n")
; fprintf(fp "#-   NOISE MARGIN  G1 - G2     -#\n")
; fprintf(fp "#-------------------------------#\n")
; fprintf(fp "NMH = %10.6f\n" nmh_12)
; fprintf(fp "NML = %10.6f\n" nml_12)

; fprintf(fp "#-------------------------------#\n")
; fprintf(fp "#-   NOISE MARGIN  G2 - G1     -#\n")
; fprintf(fp "#-------------------------------#\n")
; fprintf(fp "NMH = %10.6f\n" nmh_21)
; fprintf(fp "NML = %10.6f\n" nml_21)

; fprintf(fp "#-------------------------------#\n")
; fprintf(fp "#-        NOISE MARGIN         -#\n")
; fprintf(fp "#-------------------------------#\n")
; fprintf(fp "Min(NMH) = %10.6f\n" nmh)
; fprintf(fp "Min(NML) = %10.6f\n" nml)
; fprintf(fp "SNM = %10.6f\n" snm)

close(fp)

; end of file
