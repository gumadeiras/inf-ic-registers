; nsc.ocn

; set correct license for checkout
envSetVal("license" "ADELicenseCheckoutOrder"  'string "GXL,L,XL")

; set up simulation environment
simulator('spectre)
design("./netlist")
resultsDir(".")

fp = outfile("./RiseFall_NoiseMargin.txt", "w")
fprintf(fp "\t\t Tempos de Propagação \t\t \n\n")

analysis('tran ?stop 60n ?maxstep 3p)

run()

selectResults('tran)

Trise = riseTime( v("OUT_tran") 0 nil 0.85 nil 10 90 t "time")

Tfall = riseTime( v("OUT_tran") 0.85 nil 0 nil 10 90 t "time")

fprintf(fp "-------Transient 1--------------\n")

ocnPrint(?output fp Trise)
ocnPrint(?output fp Tfall)

Trise = riseTime( v("OUT_tran" ?result "transient2-tran") 0 nil 0.85 nil 10 90 t "time")

Tfall = riseTime( v("OUT_tran" ?result "transient2-tran") 0.85 nil 0 nil 10 90 t "time")

fprintf(fp "\n\n-------Transient 2--------------\n")

ocnPrint(?output fp Trise)
ocnPrint(?output fp Tfall)

Trise = riseTime( v("OUT_tran" ?result "transient3-tran") 0 nil 0.85 nil 10 90 t "time")

Tfall = riseTime( v("OUT_tran" ?result "transient3-tran") 0.85 nil 0 nil 10 90 t "time")

fprintf(fp "\n\n-------Transient 3--------------\n")

ocnPrint(?output fp Trise)
ocnPrint(?output fp Tfall)

;*****************START NOISE MARGIN ANALYSIS***********

delete( 'analysis 'tran )

analysis('dc ?saveOppoint t ?oppoint "rawfile")

run()

selectResults('dc)

fprintf(fp "\n\n-------Noise Margin--------------\n\n")

gvtc1 = deriv(v("OUT_dc"))

;------------------------------------------------
; determine input/output margins for gate 1
;------------------------------------------------
; verifies both positive and negative gains
vil1 = cross(gvtc1 -1 1 'either)
vih1 = cross(gvtc1 -1 2 'either)
if( vil1 == nil (vil1 = cross(gvtc1 1 1 'either)))
if( vih1 == nil (vih1 = cross(gvtc1 1 2 'either)))

; considerating gate unateness, sometimes voh and vol must be swapped
voh1 = value(v("OUT_dc") vil1)
vol1 = value(v("OUT_dc") vih1)
if( voh1 < vol1 then
	aux = voh1
	voh1 = vol1
	vol1 = aux
)

fprintf(fp "VIL  = %10.6f\n" vil1)
fprintf(fp "VIH  = %10.6f\n" vih1)
fprintf(fp "VOL  = %10.6f\n" vol1)
fprintf(fp "VOH  = %10.6f\n" voh1)
fprintf(fp "NMl = %10.6f\n" vil1 - vol1)
fprintf(fp "NMh = %10.6f\n" voh1 - vih1)

close(fp)
