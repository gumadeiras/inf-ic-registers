teste de nand com finfet 16nm
simulator lang=spice
.lib '../PTM-MG/modelfiles/models' ptm16lstp
.lib '../library_16nmlstp' standardCells

.param

.option post=2
.global gnd! vdd!

*****************define main circuit****************************
xInvA ainv a vdd! gnd! inv
xInvB binv b vdd! gnd! inv

xNandtran a b OUT_tran vdd gnd! nand

xInvO OUT outinv vdd! gnd! inv

c0 outinv gnd! 2f $load capacitance, como saber o valor da carga?

xNanddc vdd! VN0 OUT_dc vdd! gnd! nand
c1 OUT_dc gnd! 2f

***********************define stimuli*************************
*agora ligar os nodes globais vdd! e gnd!
vvdd vdd! 0 0.85V
vgnd gnd! 0 0V
Vaux vdd vdd! 0V $fonte auxiliar para obter consumo da celula

VN0 VN0 0

*agora criar os sinais em A e B
va ainv 0 DC=0.0 $ pulse 'a1' 'a2' 0 50p 50p 1n 2n $primeiro mantem entrada A fixa
vb binv 0 0 pulse 0 0.85 0 50p 50p 1.5n 3n $alterando entrada B em pulsos de 0 a 0.85
*com rise e fall de 50p e periodo de 4n

*****************************Analysis options***********************************
.tran STEP=5p STOP=50n
.dc VN0 0 0.85 0.00025

.measure tran Iint INTEG i(Vaux) FROM=0n TO=50n
.measure tran Iavg AVG abs(i(Vaux)) FROM=0n TO=50n

.measure tran Pavg PARAM='Iavg*0.85'
.measure tran Pint PARAM='Iint*0.85/50n'

**************************ALTER*****************************
.alter case 2: entrada a oscilando
va ainv 0 DC=0.0 pulse 0 0.85 0 50p 50p 1.5n 3n
vb binv 0 DC=0.0

.alter case 3: ambas entradas oscilando
va ainv 0 DC=0.0 pulse 0 0.85 0 50p 50p 1.5n 3n
vb binv 0 DC=0.0 pulse 0 0.85 0 50p 50p 2n 4n
.end
simulatorOptions options reltol=1e-3 vabstol=1e-6 iabstol=1e-12 temp=27 \
    tnom=27 scalem=1.0 scale=1.0 gmin=1e-12 rforce=1 maxnotes=5 maxwarns=5 \
    digits=5 cols=80 pivrel=1e-3 sensfile="psf/sens.output" \
    checklimitdest=psf
tran tran stop=6e-08 maxstep=3e-12 write="spectre.ic" \
    writefinal="spectre.fc" annotate=status maxiters=5
finalTimeOP info what=oppoint where=rawfile
modelParameter info what=models where=rawfile
element info what=inst where=rawfile
outputParameter info what=output where=rawfile
designParamVals info what=parameters where=rawfile
primitives info what=primitives where=rawfile
subckts info what=subckts where=rawfile
saveOptions options save=allpub
