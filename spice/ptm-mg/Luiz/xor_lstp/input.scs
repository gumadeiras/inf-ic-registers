XOR com transmission gate
simulator lang=spice

.lib '../PTM-MG/modelfiles/models' ptm16lstp
.lib '../library_16nmlstp' standardCells

.param
.option post=2
.global gnd! vdd!

***************************** define circuit *******************
xInvA invA A vdd! gnd! inv
xInvB invB B vdd! gnd! inv

xXor IN_A IN_B OUT_tran vdd gnd! xor

xInvO OUT_tran outinv vdd! gnd! inv

c0 outinv gnd! 2f

xXor2 vdd! VN0 OUT_dcA vdd! gnd! xor
c1 OUT_dcA gnd! 2f

xXor3 VN0 vdd! OUT_dcB vdd! gnd! xor
c2 OUT_dcB gnd! 2f
******************************define stimuli********************
Va invA 0 DC=0.85
Vb invB 0 0 pulse 0 0.85 0 50p 50p 1n 2n $frequencia 500MHz

vvdd vdd! 0 0.85V
vgnd gnd! 0 0V

VN0 VN0 0

Vaux vdd vdd! 0V $fonte auxiliar para medir consumo
VauxA IN_A A DC=0V
VauxB IN_B B DC=0V

*************************Analysis*********************************
.tran STEP=5p STOP=50n
.dc VN0 0 0.85 0.00025

.measure tran Iint INTEG i(Vaux) FROM=0n TO=50n
.measure tran Iavg AVG abs(i(Vaux)) FROM=0n TO=50n

.measure tran Pavg PARAM='Iavg*0.85'
.measure tran Pint PARAM='Iint*0.85/50n'

.measure tran IintA INTEG i(VauxA) FROM=0n TO=50n
.measure tran IavgA AVG abs(i(VauxA)) FROM=0n TO=50n

.measure tran PavgA PARAM='IavgA*0.85'
.measure tran PintA PARAM='IintA*0.85/50n'

.measure tran IintB INTEG i(VauxB) FROM=0n TO=50n
.measure tran IavgB AVG abs(i(VauxB)) FROM=0n TO=50n

.measure tran PavgB PARAM='IavgB*0.85'
.measure tran PintB PARAM='IintB*0.85/50n'

***************************alter***************************
.alter case 2: entrada A em VDD
Va invA 0 DC=0.0V
Vb invB 0 DC=0.0 pulse 0 0.85 0 50p 50p 1n 2n

.alter case 3: entrada B em GND
Va invA 0 DC=0.0 pulse 0 0.85 0 50p 50p 1n 2n
Vb invB 0 DC=0.85

.alter case 4: entrada B em VDD
Va invA 0 DC=0.0 pulse 0 0.85 0 50p 50p 1n 2n
Vb invB 0 DC=0.0

.alter case 5: ambas entradas oscilando
Va invA 0 DC=0.0 pulse 0 0.85 0 50p 50p 1n 2n
Vb invB 0 DC=0.0 pulse 0 0.85 0 50p 50p 1.5n 3n

.end
simulatorOptions options reltol=1e-3 vabstol=1e-6 iabstol=1e-12 temp=27 \
    tnom=27 scalem=1.0 scale=1.0 gmin=1e-12 rforce=1 maxnotes=5 maxwarns=5 \
    digits=5 cols=80 pivrel=1e-3 sensfile="psf/sens.output" \
    checklimitdest=psf
dcOp dc write="spectre.dc" maxiters=150 maxsteps=10000 annotate=status
dcOpInfo info what=oppoint where=rawfile
modelParameter info what=models where=rawfile
element info what=inst where=rawfile
outputParameter info what=output where=rawfile
designParamVals info what=parameters where=rawfile
primitives info what=primitives where=rawfile
subckts info what=subckts where=rawfile
saveOptions options save=allpub
