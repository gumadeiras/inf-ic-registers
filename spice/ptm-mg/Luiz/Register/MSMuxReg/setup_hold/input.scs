parameters delay=1.3e-10
*mux based master slave register
simulator lang=spice
.lib '../../../PTM-MG/modelfiles/models' ptm16lstp
.lib '../../../library_16nmlstp' standardCells

.option post=2
.global gnd! vdd!

**********DEFINE CIRCUIT************

xInv0 D0 D1 vdd! gnd! inv
xInv1 D1 D vdd! gnd! inv

xInv2 CLK0 CLK1 vdd! gnd! inv
xInv3 CLK1 CLK vdd! gnd! inv

xMuxReg D CLK Q vdd gnd! MSMuxReg

xInvout Q invOUT vdd gnd! inv

c0 invOUT gnd! 2f
*************************************

*****DEFINE STIMULI***********

Vdd vdd 0 0.85V
Vvdd vdd! 0 0.85V
Vgnd gnd! 0 0.0V

Vclock CLK0 gnd! DC = 0 pulse 1n 0.85 0 20p 20p 1n 2n
Vd D0 gnd! PWL 0n 0.0V "2.1n-delay" 0.0V "2.15n-delay" 0.85V 4n 0.85V

*****************************************************

***********DEFINE ANALYSIS**********

.tran STEP=2p STOP=4n

.end
simulatorOptions options reltol=1e-3 vabstol=1e-6 iabstol=1e-12 temp=27 \
    tnom=27 scalem=1.0 scale=1.0 gmin=1e-12 rforce=1 maxnotes=5 maxwarns=5 \
    digits=5 cols=80 pivrel=1e-3 sensfile="psf/sens.output" \
    checklimitdest=psf
tran tran stop=4e-09 start=1e-09 write="spectre.ic" \
    writefinal="spectre.fc" annotate=status maxiters=5
finalTimeOP info what=oppoint where=rawfile
modelParameter info what=models where=rawfile
element info what=inst where=rawfile
outputParameter info what=output where=rawfile
designParamVals info what=parameters where=rawfile
primitives info what=primitives where=rawfile
subckts info what=subckts where=rawfile
saveOptions options save=allpub
