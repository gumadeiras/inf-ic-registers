parameters Per=2e-09
*mux based master slave register
simulator lang=spice
.lib '../../PTM-MG/modelfiles/models' ptm16lstp
.lib '../../library_16nmlstp' standardCells

.param
*.param Per = 2n
.option post=2
.global gnd! vdd!

**********DEFINE CIRCUIT************

xInv0 notD D vdd! gnd! inv

xMuxReg D CLK OUT_tran vdd gnd! MSMuxReg

xInv1 OUT_tran invOUT vdd gnd! inv

c0 invOUT gnd! 2f

xInvCLK notCLK CLK vdd! gnd! inv

*xMuxReg2 D CLK2 Q vdd! gnd! MSMuxReg

*xInv2 Q D vdd! gnd! inv

*************************************

*****DEFINE STIMULI***********

Vdd vdd 0 0.85V
Vvdd vdd! 0 0.85V
Vgnd gnd! 0 0.0V

Vclock notCLK gnd! DC = 0 pulse 0 0.85 0 10p 10p "Per/2" "Per"
Vd notD gnd! DC = 0 pulse 0 0.85 0 50p 50p 2n 4n

*Vclk CLK2 gnd! DC = 0 pulse 0 0.85 0 10p 10p "Per/2" "Per"

*****************************************************

***********DEFINE ANALYSIS**********

.tran STEP=2p STOP=15n

.end
simulatorOptions options reltol=1e-3 vabstol=1e-6 iabstol=1e-12 temp=27 \
    tnom=27 scalem=1.0 scale=1.0 gmin=1e-12 rforce=1 maxnotes=5 maxwarns=5 \
    digits=5 cols=80 pivrel=1e-3 sensfile="psf/sens.output" \
    checklimitdest=psf
tran tran stop=3e-08 maxstep=5e-12 write="spectre.ic" \
    writefinal="spectre.fc" annotate=status maxiters=5
finalTimeOP info what=oppoint where=rawfile
modelParameter info what=models where=rawfile
element info what=inst where=rawfile
outputParameter info what=output where=rawfile
designParamVals info what=parameters where=rawfile
primitives info what=primitives where=rawfile
subckts info what=subckts where=rawfile
saveOptions options save=allpub
