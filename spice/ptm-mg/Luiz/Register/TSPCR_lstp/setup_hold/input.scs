parameters delay=1.15e-10
*True Single Phase Clock Register
simulator lang=spice
.lib '../../../PTM-MG/modelfiles/models' ptm16lstp
.lib '../../../library_16nmlstp' standardCells

.param
.option post=2
.global gnd! vdd!
.IC v(OUT_tran) = 0.0 v(D) = 0.0 v(D1) = 0.85 v(D0) = 0.0
*********DEFINE CIRCUIT************
xInvCLK0 CLK0 CLK1 vdd! gnd! inv
xInvCLK1 CLK1 CLK vdd! gnd! inv

xInv0 D0 D1 vdd2! gnd! inv
xInv1 D1 D vdd2! gnd! inv

xReg D CLK OUT_tran vdd gnd! TSPCR

xInvout OUT_tran Qinv vdd! gnd! inv

c0 Qinv gnd! 2f

*********DEFINE SOURCES***********
vvdd vdd! 0 0.85V
vgnd gnd! 0 0V
vvdd2 vdd2! 0 0.85

Vdd vdd 0 0.85V

VCLK CLK0 0 DC = 0 pulse 0 0.85 0 25p 25p 1n 2n
Vd D0 0 PWL 0n 0.0V "2.1n-delay" 0.0V "2.15n-delay" 0.85V 4n 0.85V
*************ANALYSIS******************
.tran STEP=2p STOP=4n UIC
******************************************
.end
simulatorOptions options reltol=1e-3 vabstol=1e-6 iabstol=1e-12 temp=27 \
    tnom=27 scalem=1.0 scale=1.0 gmin=1e-12 rforce=1 maxnotes=5 maxwarns=5 \
    digits=5 cols=80 pivrel=1e-3 sensfile="psf/sens.output" \
    checklimitdest=psf
tran tran stop=4e-09 start=1e-09 write="spectre.ic" \
    writefinal="spectre.fc" annotate=status maxiters=5
finalTimeOP info what=oppoint where=rawfile
modelParameter info what=models where=rawfile
element info what=inst where=rawfile
outputParameter info what=output where=rawfile
designParamVals info what=parameters where=rawfile
primitives info what=primitives where=rawfile
subckts info what=subckts where=rawfile
saveOptions options save=allpub
