parameters Per=2.5e-10
*True Single Phase Clock Register
simulator lang=spice

.lib '../../PTM-MG/modelfiles/models' ptm16lstp
.lib '../../library_16nmlstp' standardCells

.param
*.param Per = 4n
.option post=2
.global gnd! vdd! Per

********DEFINE CIRCUIT*************

*xTSPCR0 D0 CLK Q0 vdd gnd! TSPCR
*xTSPCR1 Q0 CLK D0 vdd gnd! TSPCR

xTSPCR2 D CLK Q vdd gnd! TSPCR
xInv Q D vdd! gnd! inv

***********************************

********DEFINE STIMULI***********
Vdd vdd 0 0.85V

vvdd vdd! 0 0.85V
vgnd gnd! 0 0.0V

Vclk CLK gnd! DC = 0 pulse 0V 0.85V 0 5p 5p "Per/2" "Per"

*********************************

*********DEFINE ANALYSIS*********

*.IC V(D0) = 0.85V
*.IC V(Q0) = 0.0V
.tran STEP = 2p STOP = 20n UIC

**********************************

.end
simulatorOptions options reltol=1e-3 vabstol=1e-6 iabstol=1e-12 temp=27 \
    tnom=27 scalem=1.0 scale=1.0 gmin=1e-12 rforce=1 maxnotes=5 maxwarns=5 \
    digits=5 cols=80 pivrel=1e-3 sensfile="psf/sens.output" \
    checklimitdest=psf
tran tran stop=1.2e-08 maxstep=1e-11 write="spectre.ic" \
    writefinal="spectre.fc" annotate=status maxiters=5
finalTimeOP info what=oppoint where=rawfile
modelParameter info what=models where=rawfile
element info what=inst where=rawfile
outputParameter info what=output where=rawfile
designParamVals info what=parameters where=rawfile
primitives info what=primitives where=rawfile
subckts info what=subckts where=rawfile
saveOptions options save=allpub
