; nsc.ocn
; ocean <<< "load(\"tran.ocn\");exit"

; set correct license for checkout
envSetVal("license" "ADELicenseCheckoutOrder"  'string "GXL,L,XL")

; set up simulation environment
setup(?numberNotation 'engineering ?precision 6)
simulator('spectre)
design("./netlist/netlist")
resultsDir(".")
; open output port for writing out results to a file
of = outfile("./run.txt" "w")
desVar( "DelayTime" 0ps)

analysis('tran ?stop 10n)
run()

selectResults('tran)

paramAnalysis( "DelayTime" ?start 0ps ?stop 50ps ?step 1ps)
; paramAnalysis( "DelayTime" ?center 3.025ns ?span 150ps)
paramRun()

; regpwr = 0.85*average(abs(i("Vdreg:p" ?result "transient3-tran")))
; regeng = 0.85*average(abs(i("Vdreg:p" ?result "transient3-tran")))*10n
; fprintf(of "Pwr  = %e\n" regpwr)
; fprintf(of "Engy = %e\n\n" regeng)

close(of)

; end of file
