; set correct license for checkout
envSetVal("license" "ADELicenseCheckoutOrder"  'string "GXL,L,XL")

; set up simulation environment
setup(?precision 15)
simulator('spectre)
option(
   ?categ 'turboOpts
   'uniMode "APS"
)
design("./sizing/netlist")
resultsDir(".")
/**************************************************************************************************
*   Script varia delay de subida da entrada D através de uma análise paramétrica,             *
*   pega a última onda da saída que subiu acima de 90% do VDD e calcula os tempos relevantes. *
*   Para analisar entrada descendo, trocar a linha                        *
*   "if( valY > 0.8075 then" por "if( valY < xxx then"                    *
*                                                 *
*                                                 *
*   Para análise de hold time, são necessárias mudanças no netlist                *
***************************************************************************************************/

/***************************************************************
*                                                              *
*                        (abLastY wave)                        *
*                                                              *
*          Return the last Y value from the waveform           *
*            Funcao do Andrew                                  *
***************************************************************/
(defun abLastY (wave)
  (cond
    ((drIsWaveform wave)
     (let (len vec)
       (setq vec (drGetWaveformYVec wave))
       (setq len (drVectorLength vec))
       (drGetElem vec (sub1 len))
       )
     )
    ((famIsFamily wave)
     (famMap 'abLastY wave))
    (t
      (error "abLastY: can't handle %L\n" wave)
      )
    )
  ) ; defun abLastY

fp = outfile("./rsetup.csv", "w")

fprintf(fp "Transition,Wn,DelaySetup,DelayHold,C2Qsetup,C2Qhold,Setup,Hold\n")

;----------Parametros para simulacao-------------

desVar( "Wn" 1 )
desVar( "delay" 0ps )
analysis( 'tran ?start 1n ?stop 4.5n )

paramAnalysis( "delay" ?start 30ps ?stop 10ps ?step -1ps
    paramAnalysis( "Wn" ?start 1 ?stop 5 ?step 1 )
    )
paramRun()

;************************ 0 --> 1 ****************************************************
;---------loop para obter Tsetup----------------
(foreach Wn '(1, 2, 3, 4, 5);, 3, 4, 5, 6, 7, 8, 9, 10
    foreach( delay famGetSweepValues( v("QS" ?result "tran") ) ;famGetSweepValues cria uma lista com os valores parametrizados da familia de ondas Q
        auxSwave = famValue( v("QS" ?result "tran") delay ) ;famValue pega a onda especifica da familia com o valor do parametro desejado
        wave = famValue(auxSwave Wn)
        valY = abLastY(wave)
        if( valY > 0.8075 then
            waveS = wave
            delayS = delay
           )
    )
    ;------------------------------------------------

    ;-----------loop para obter Thold----------------
    aux = 0

    foreach( delay famGetSweepValues( v("QH" ?result "tran") ) ;famGetSweepValues cria uma lista com os valores parametrizados da familia de ondas Q
        auxHwave = famValue( v("QH" ?result "tran") delay ) ;famValue pega a onda especifica da familia com o valor do parametro desejado
        wave = famValue(auxHwave Wn)
        valY = abLastY(wave)
        if( valY > 0.8075 && aux == 0 then
            waveH = wave
            delayH = delay
            aux = 1
           )
    )

Tsetup = delay( ?wf1 leafValue( v("DS" ?result "tran") "delay" delayS "Wn" Wn ) ?value1 0.425 ?edge1 'either ?wf2 leafValue( v("CLKS" ?result "tran") "delay" delayS "Wn" Wn ) ?value2 0.425 ?edge2 'rising )

Thold = delay( ?wf1 leafValue( v("CLKH" ?result "tran") "delay" delayH "Wn" Wn ) ?value1 0.425 ?edge1 'rising ?wf2 leafValue( v("DH" ?result "tran") "delay" delayH "Wn" Wn ) ?value2 0.425 ?edge2 'either )

TCtQS = delay( ?wf1 leafValue( v("CLKS" ?result "tran") "delay" delayS "Wn" Wn ) ?value1 0.425 ?edge1 'rising ?wf2 leafValue( v("QS" ?result "tran") "delay" delayS "Wn" Wn ) ?value2 0.425 ?edge2 'either )

TCtQH = delay( ?wf1 leafValue( v("CLKH" ?result "tran") "delay" delayH "Wn" Wn ) ?value1 0.425 ?edge1 'rising ?wf2 leafValue( v("QH" ?result "tran") "delay" delayH "Wn" Wn ) ?value2 0.425 ?edge2 'either )

; fprintf(fp "\t\t 0 --> 1\n\n")
; fprintf(fp "Setup Time last transition\n")
; fprintf(fp "T_setup = %e\n" Tsetup)

; fprintf(fp "\nrespective Clock to Q delay\n")
; fprintf(fp "TCtQ = %e\n" TCtQS)

; fprintf(fp "\n Delay value for last transition\n")
; fprintf(fp "delay = %e\n\n" delayS)

; fprintf(fp "Hold Time last transition\n")
; fprintf(fp "T_hold = %e\n" Thold)

; fprintf(fp "\nrespective Clock to Q delay\n")
; fprintf(fp "TCtQ = %e\n" TCtQH)

; fprintf(fp "\n Delay value for last transition\n")
; fprintf(fp "delay = %e\n" delayH)

; fprintf(fp "Wn = %d\n\n" Wn)

;;;;;; fprintf(fp "Transition,Wn,DelaySetup,DelayHold,C2Qsetup,C2Qhold,Setup,Hold\n")
fprintf(fp "01,%d,%e,%e,%e,%e,%e,%e\n" Wn delayS delayH TCtQS TCtQH Tsetup Thold)

)

;************************ 1 --> 0 ****************************************************
;---------loop para obter Tsetup----------------

(foreach Wn '(1, 2, 3, 4, 5);, 3, 4, 5, 6, 7, 8, 9, 10, 11, 12, 13, 14, 15, 16, 17, 18, 19, 20)

    foreach( delay famGetSweepValues( v("QS" ?result "timeSweep_cloned_1-tran") ) ;famGetSweepValues cria uma lista com os valores parametrizados da familia de ondas Q
        auxSwave = famValue( v("QS" ?result "tran") delay ) ;famValue pega a onda especifica da familia com o valor do parametro desejado
        wave = famValue(auxSwave Wn)
        valY = abLastY(wave)
        if( valY > 0.8075 then
            waveS = wave
            delayS = delay
           )
    )
    ;------------------------------------------------

    ;-----------loop para obter Thold----------------
    aux = 0
    foreach( delay famGetSweepValues( v("QH" ?result "timeSweep_cloned_1-tran") ) ;famGetSweepValues cria uma lista com os valores parametrizados da familia de ondas Q
        auxHwave = famValue( v("QH" ?result "tran") delay ) ;famValue pega a onda especifica da familia com o valor do parametro desejado
        wave = famValue(auxHwave Wn)
        valY = abLastY(wave)
        if( valY > 0.8075 && aux == 0 then
            waveH = wave
            delayH = delay
            aux = 1
           )
    )

Tsetup = delay( ?wf1 leafValue( v("DS" ?result "timeSweep_cloned_1-tran") "delay" delayS "Wn" Wn ) ?value1 0.425 ?edge1 'either ?wf2 leafValue( v("CLKS" ?result "timeSweep_cloned_1-tran") "delay" delayS "Wn" Wn ) ?value2 0.425 ?edge2 'rising )

Thold = delay( ?wf1 leafValue( v("CLKH" ?result "timeSweep_cloned_1-tran") "delay" delayH "Wn" Wn ) ?value1 0.425 ?edge1 'rising ?wf2 leafValue( v("DH" ?result "timeSweep_cloned_1-tran") "delay" delayH "Wn" Wn ) ?value2 0.425 ?edge2 'either )

TCtQS = delay( ?wf1 leafValue( v("CLKS" ?result "timeSweep_cloned_1-tran") "delay" delayS "Wn" Wn ) ?value1 0.425 ?edge1 'rising ?wf2 leafValue( v("QS" ?result "timeSweep_cloned_1-tran") "delay" delayS "Wn" Wn ) ?value2 0.425 ?edge2 'either )

TCtQH = delay( ?wf1 leafValue( v("CLKH" ?result "timeSweep_cloned_1-tran") "delay" delayH "Wn" Wn ) ?value1 0.425 ?edge1 'rising ?wf2 leafValue( v("QH" ?result "timeSweep_cloned_1-tran") "delay" delayH "Wn" Wn ) ?value2 0.425 ?edge2 'either )

; fprintf(fp "\t\t 1 --> 0\n\n")
; fprintf(fp "Setup Time last transition\n")
; fprintf(fp "T_setup = %e\n" Tsetup)

; fprintf(fp "\nrespective Clock to Q delay\n")
; fprintf(fp "TCtQ = %e\n" TCtQS)

; fprintf(fp "\n Delay value for last transition\n")
; fprintf(fp "delay = %e\n\n" delayS)

; fprintf(fp "Hold Time last transition\n")
; fprintf(fp "T_hold = %e\n" Thold)

; fprintf(fp "\nrespective Clock to Q delay\n")
; fprintf(fp "TCtQ = %e\n" TCtQH)

; fprintf(fp "\n Delay value for last transition\n")
; fprintf(fp "delay = %e\n" delayH)

; fprintf(fp "Wn = %d\n\n" Wn)

;;;;;; fprintf(fp "Transition,Wn,DelaySetup,DelayHold,C2Qsetup,C2Qhold,Setup,Hold\n")
fprintf(fp "10,%d,%e,%e,%e,%e,%e,%e\n" Wn delayS delayH TCtQS TCtQH Tsetup Thold)

)
close(fp)
