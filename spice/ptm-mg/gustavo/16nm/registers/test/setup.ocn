; set correct license for checkout
envSetVal("license" "ADELicenseCheckoutOrder"  'string "GXL,L,XL")

; set up simulation environment
setup(?precision 15)
simulator('spectre)
design("./netlist/netlist")
resultsDir(".")
/***************************************************************
*                                                              *
*                        (abLastY wave)                        *
*                                                              *
*          Return the last Y value from the waveform           *
*                                                              *
***************************************************************/
(defun abLastY (wave)
  (cond
    ((drIsWaveform wave)
     (let (len vec)
       (setq vec (drGetWaveformYVec wave))
       (setq len (drVectorLength vec))
       (drGetElem vec (sub1 len))
       )
     )
    ((famIsFamily wave)
     (famMap 'abLastY wave))
    (t
      (error "abLastY: can't handle %L\n" wave)
      )
    )
  ) ; defun abLastY

fp = outfile("./Tsetup_TCtQ.txt", "w")

desVar( "delay" 120ps )
analysis( 'tran ?start 1n ?stop 4n )

paramAnalysis( "delay" ?start 115ps ?stop 110ps ?step -1ps )
paramRun()

foreach( delay famGetSweepValues( v("OUT_tran" ?result "tran") )
	wave = famValue( v("OUT_tran" ?result "tran") delay )
	valY = abLastY(wave)
	if( valY > 0.8075 then
		wave2 = wave
		delay2 = delay
	   )
)

plot(wave2)

Tsetup = delay( ?wf1 leafValue( v("D" ?result "tran") "delay" delay2 ) ?value1 0.425 ?edge1 'either ?wf2 leafValue( v("CLK" ?result "tran") "delay" delay2 ) ?value2 0.425 ?edge2 'rising ?nth2 1 )

TCtQ = delay( ?wf1 leafValue( v("CLK" ?result "tran") "delay" delay2 ) ?value1 0.425 ?edge1 'rising ?nth1 1 ?wf2 leafValue( v("OUT_tran" ?result "tran") "delay" delay2 ) ?value2 0.425 ?edge2 'either ?nth2 1 )

fprintf(fp "Setup Time last transition\n")
fprintf(fp "T_setup = %e\n" Tsetup)

fprintf(fp "\nrespective Clock to Q delay\n")
fprintf(fp "TCtQ = %e\n" TCtQ)

fprintf(fp "\n Delay value for last transition\n")
fprintf(fp "delay = %e\n" delay2)

close(fp)
