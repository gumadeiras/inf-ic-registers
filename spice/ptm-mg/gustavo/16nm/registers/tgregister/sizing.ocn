; set correct license for checkout
envSetVal("license" "ADELicenseCheckoutOrder"  'string "GXL,L,XL")

; set up simulation environment
setup(?precision 15)
simulator('spectre)
option(
   ?categ 'turboOpts
   'uniMode "APS"
)
design("./sizing/netlist")
resultsDir(".")
/**************************************************************************************************
*   Script varia delay de subida da entrada D através de uma análise paramétrica,             *
*   pega a última onda da saída que subiu acima de 90% do VDD e calcula os tempos relevantes. *
*   Para analisar entrada descendo, trocar a linha                        *
*   "if( valY > 0.8075 then" por "if( valY < xxx then"                    *
*                                                 *
*                                                 *
*   Para análise de hold time, são necessárias mudanças no netlist                *
***************************************************************************************************/

/***************************************************************
*                                                              *
*                        (abLastY wave)                        *
*                                                              *
*          Return the last Y value from the waveform           *
*            Funcao do Andrew                                  *
***************************************************************/
(defun abLastY (wave)
  (cond
    ((drIsWaveform wave)
     (let (len vec)
       (setq vec (drGetWaveformYVec wave))
       (setq len (drVectorLength vec))
       (drGetElem vec (sub1 len))
       )
     )
    ((famIsFamily wave)
     (famMap 'abLastY wave))
    (t
      (error "abLastY: can't handle %L\n" wave)
      )
    )
  ) ; defun abLastY

fp = outfile("./rsetup.txt", "w")

desVar( "Wn" 1 )
desVar( "delay" 120ps )
analysis( 'tran ?start 1n ?stop 4.5n )

paramAnalysis( "delay" ?start 0ps ?stop 20ps ?step 1ps
    paramAnalysis( "Wn" ?start 1 ?stop 10 ?step 1 )
    )
paramRun()

; foreach( delay famGetSweepValues( v("Q" ?result "tran") ) ;famGetSweepValues cria uma lista com os valores parametrizados da familia de ondas Q
;     wave = famValue( v("Q" ?result "tran") delay ) ;famValue pega a onda especifica da familia com o valor do parametro desejado
;     valY = abLastY(wave)
;     if( valY > 0.8075 then
;         wave2 = wave
;         delay2 = delay
;        )
; )

; plot(wave2)

; regpwr = 0.85*average(abs(i("X0:p" ?result "tran")))
; regeng = 0.85*average(abs(i("X0:p" ?result "tran")))*8n
; Tsetup = delay( ?wf1 leafValue( v("D" ?result "tran") "delay" delay2 ) ?value1 0.425 ?edge1 'either ?wf2 leafValue( v("CLK" ?result "tran") "delay" delay2 ) ?value2 0.425 ?edge2 'rising ?nth2 1 )

; ; TCtQ = delay( ?wf1 leafValue( v("CLK" ?result "tran") "delay" delay2 ) ?value1 0.425 ?edge1 'rising ?nth1 1 ?wf2 leafValue( v("Q" ?result "tran") "delay" delay2 ) ?value2 0.425 ?edge2 'either)

; fprintf(fp "Setup Time last transition\n")
; fprintf(fp "T_setup = %e\n" Tsetup)

; fprintf(fp "\nrespective Clock to Q delay\n")
; fprintf(fp "TCtQ = %e\n" TCtQ)

; fprintf(fp "\n Delay value for last transition\n")
; fprintf(fp "delay = %e\n" delay2)

close(fp)
