; nsc.ocn
; ocean <<< "load(\"tran.ocn\");exit"

; set correct license for checkout
envSetVal("license" "ADELicenseCheckoutOrder"  'string "GXL,L,XL")

; set up simulation environment
setup(?numberNotation 'engineering ?precision 6)
simulator('spectre)
; design("./design/netlist")
design("./16nm/tran/netlist")
resultsDir(".")
; open output port for writing out results to a file
of = outfile("./tran.txt" "w")

; desVar("vdd" 0.85)
; halfVdd = evalstring(desVar("vdd"))/2.0
analysis('tran ?stop 20n)
run()

selectResults('tran)

; delay(?wf1 v("/D1" ?result "tran") ?value1 0.5 ?edge1 "rising"  ?nth1 1 ?td1 0.0 ?wf2 v("/CMPLT32" ?result "tran") ?value2 0.5 ?edge2 "rising"  ?nth2 1 ?td2 nil ?stop nil ?multiple nil)
; o de cima esta errado, certo:
; halfVdd = evalstring(desVar("simVdd"))/2.0
; delay(?wf1 v("/D1" ?result "tran") ?value1 halfVdd ?edge1 "rising"  ?nth1 1 ?td1 0.0 ?wf2 v("/CMPLT32" ?result "tran") ?value2 halfVdd ?edge2 "rising"  ?nth2 1 ?td2 nil ?stop nil ?multiple nil)

;------------------------------------------------
; calculate rise and fall times
;------------------------------------------------
invtr = riseTime(v("outINV") 0 nil 0.85 nil 10 90 t "time")
invtf = riseTime(v("outINV") 0.85 nil 0 nil 90 10 t "time")

nandtr=riseTime(v("outNAND") 0 nil 0.85 nil 10 90 t "time")
nandtf=riseTime(v("outNAND") 0.85 nil 0 nil 90 10 t "time")
; nandtr0 = cross(v("outNAND") 0.085 2 'rising)
; nandtr1 = cross(v("outNAND") 0.765 2 'rising)
; nandtr  = nandtr1-nandtr0

; nandtf0 = cross(v("outNAND") 0.765 2 'falling)
; nandtf1 = cross(v("outNAND") 0.085 2 'falling)
; nandtf  = nandtf1-nandtf0

; t = 0, t = 0.85
nortr=riseTime(v("outNOR") 0 nil 0.85 nil 10 90 t "time")
nortf=riseTime(v("outNOR") 0.85 nil 0 nil 90 10 t "time")

xortr=riseTime(v("outXOR") 0 nil 0.85 nil 10 90 t "time")
xortf=riseTime(v("outXOR") 0.85 nil 0 nil 90 10 t "time")

tgxortr=riseTime(v("outTGXOR") 0 nil 0.85 nil 10 90 t "time")
tgxortf=riseTime(v("outTGXOR") 0.85 nil 0 nil 90 10 t "time")

;------------------------------------------------
; calculate propagation delay
;------------------------------------------------
for(xx 1 5
invtplh = delay(v("outBUF0") 0.425 xx 'falling v("outINV") 0.425 xx 'rising)
invtphl = delay(v("outBUF0") 0.425 xx 'rising v("outINV") 0.425 xx 'falling)
fprintf(of "#--- CROSS --------- VALUE(S) ---#\n")
fprintf(of "Tphl: %n            %e\n" xx invtphl)
fprintf(of "Tplh: %n            %e\n" xx invtplh)
)

nandtplh = delay(v("outBUF1") 0.425 1 'falling v("outNAND") 0.425 1 'rising)
nandtphl = delay(v("outBUF1") 0.425 1 'rising v("outNAND") 0.425 1 'falling)

nortplh = delay(v("outBUF2") 0.425 1 'falling v("outNOR") 0.425 1 'rising)
nortphl = delay(v("outBUF2") 0.425 1 'rising v("outNOR") 0.425 1 'falling)

xortplh = delay(v("outBUF3") 0.425 1 'falling v("outXOR") 0.425 1 'rising)
xortphl = delay(v("outBUF3") 0.425 1 'rising v("outXOR") 0.425 1 'falling)

tgxortplh = delay(v("outBUF4") 0.425 1 'falling v("outTGXOR") 0.425 1 'rising)
tgxortphl = delay(v("outBUF4") 0.425 1 'rising v("outTGXOR") 0.425 1 'falling)

;------------------------------------------------
; calculate power and energy
;------------------------------------------------
invpwr = 0.85*average(abs(i("Vdinv:p" ?result "tran")))
inveng = 0.85*average(abs(i("Vdinv:p" ?result "tran")))*20n

nandpwr = 0.85*average(abs(i("Vdnand:p" ?result "tran")))
nandeng = 0.85*average(abs(i("Vdnand:p" ?result "tran")))*20n

norpwr = 0.85*average(abs(i("Vdnor:p" ?result "tran")))
noreng = 0.85*average(abs(i("Vdnor:p" ?result "tran")))*20n

xorpwr = 0.85*average(abs(i("Vdxor:p" ?result "tran")))
xoreng = 0.85*average(abs(i("Vdxor:p" ?result "tran")))*20n

tgxorpwr = 0.85*average(abs(i("Vdtgxor:p" ?result "tran")))
tgxoreng = 0.85*average(abs(i("Vdtgxor:p" ?result "tran")))*20n

;------------------------------------------------
; print results to the output file
;------------------------------------------------
fprintf(of "#-------------------------------#\n")
fprintf(of "#-           INVERTER          -#\n")
fprintf(of "#-------------------------------#\n")
fprintf(of "#------------RISE TIME----------#\n")
ocnPrint(?output of invtr)
fprintf(of "#------------FALL TIME----------#\n")
ocnPrint(?output of invtf)
fprintf(of "Tphl = %e\n" invtphl)
fprintf(of "Tplh = %e\n" invtplh)
fprintf(of "Tp   = %e\n" (invtphl+invtplh)/2)
fprintf(of "Pwr  = %e\n" invpwr)
fprintf(of "Engy = %e\n\n" inveng)

fprintf(of "#-------------------------------#\n")
fprintf(of "#-           NAND2             -#\n")
fprintf(of "#-------------------------------#\n")
fprintf(of "#------------RISE TIME----------#\n")
ocnPrint(?output of nandtr)
fprintf(of "#------------FALL TIME----------#\n")
ocnPrint(?output of nandtf)
fprintf(of "Tphl = %e\n" nandtphl)
fprintf(of "Tplh = %e\n" nandtplh)
fprintf(of "Tp   = %e\n" (nandtphl+nandtplh)/2)
fprintf(of "Pwr  = %e\n" nandpwr)
fprintf(of "Engy = %e\n\n" nandeng)

fprintf(of "#-------------------------------#\n")
fprintf(of "#-           NOR2              -#\n")
fprintf(of "#-------------------------------#\n")
fprintf(of "#------------RISE TIME----------#\n")
ocnPrint(?output of nortr)
fprintf(of "#------------FALL TIME----------#\n")
ocnPrint(?output of nortf)
fprintf(of "Tphl = %e\n" nortphl)
fprintf(of "Tplh = %e\n" nortplh)
fprintf(of "Tp   = %e\n" (nortphl+nortplh)/2)
fprintf(of "Pwr  = %e\n" norpwr)
fprintf(of "Engy = %e\n\n" noreng)

fprintf(of "#-------------------------------#\n")
fprintf(of "#-           XOR2              -#\n")
fprintf(of "#-------------------------------#\n")
fprintf(of "#------------RISE TIME----------#\n")
ocnPrint(?output of xortr)
fprintf(of "#------------FALL TIME----------#\n")
ocnPrint(?output of xortf)
fprintf(of "Tphl = %e\n" xortphl)
fprintf(of "Tplh = %e\n" xortplh)
fprintf(of "Tp   = %e\n" (xortphl+xortplh)/2)
fprintf(of "Pwr  = %e\n" xorpwr)
fprintf(of "Engy = %e\n\n" xoreng)

fprintf(of "#-------------------------------#\n")
fprintf(of "#-           TG XOR2           -#\n")
fprintf(of "#-------------------------------#\n")
fprintf(of "#------------RISE TIME----------#\n")
ocnPrint(?output of tgxortr)
fprintf(of "#------------FALL TIME----------#\n")
ocnPrint(?output of tgxortf)
fprintf(of "Tphl = %e\n" tgxortphl)
fprintf(of "Tplh = %e\n" tgxortplh)
fprintf(of "Tp   = %e\n" (tgxortphl+tgxortplh)/2)
fprintf(of "Pwr  = %e\n" tgxorpwr)
fprintf(of "Engy = %e\n\n" tgxoreng)

close(of)

; end of file
